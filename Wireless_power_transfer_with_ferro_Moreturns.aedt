# Ansys Electronics Desktop project, version 2024.2
materials:
  vacuum: permittivity=1
  copper: permeability=0.999991 conductivity=58000000
  iron: permeability=4000 conductivity=10300000
  ferrite: permittivity=12 permeability=1000 conductivity=0.01

design HFSSDesign1 (HFSS, HFSS Terminal Network, model units mm)
geometry:
  RectHelix1 = user_primitive(SegmentedHelix/RectHelix.dll, RectHeight=0.1mm, RectWidth=1mm, StartHelixRadius=20mm, RadiusChange=2mm, Pitch=0mm, Turns=4, SegmentsPerTurn=36, RightHanded=1)
  Box1 = box(corner=(28.393509mm, 0.0046887146mm, 0.05mm), size=(-1.0035094mm, -0.094688715mm, 0.09mm))
  Box1.unite(RectHelix1)
  coordinate_system RelativeCS1 = origin=(28.393509mm, 0.0046887146mm, 0.14mm) x=(1mm, 0mm, 0mm) y=(0mm, 1mm, 0mm)
  tx_Coil [copper] = box(corner=(0mm, -0.08mm, -0.04mm), size=(-9.2mm, 0.18mm, 0.04mm)) in RelativeCS1
  tx_Coil.unite(Box1)
  coordinate_system RelativeCS2 = origin=(-8.9697169mm, -0.0046887146mm, -0.09mm) x=(1mm, 0mm, 0mm) y=(0mm, 1mm, 0mm) in RelativeCS1
  Rectangle1 = rectangle(corner=(0mm, 0mm, 0mm), z_size=0.05mm, x_size=1mm) in RelativeCS2
  Rx_Coil [copper] = tx_Coil.duplicate_along_line(step=(-0.019716877mm, 0.05mm, 20mm), total=2) in RelativeCS2
  Rectangle2 = rectangle(corner=(-0.019716877mm, 0.05mm, 20mm), z_size=0.05mm, x_size=1.0197169mm) in RelativeCS2
  Cylinder1 [ferrite] = cylinder(axis=Z, base_centre=(-19mm, -0.5mm, -2mm), radius=28mm, height=1.5mm) in RelativeCS2
  Box3 [vacuum] = box(corner=(-75mm, -50mm, -40mm), size=(100mm, 100mm, 100mm)) in RelativeCS2
boundaries and excitations:
  Rad1: Radiation Objects=Box3
  Tx: Terminal port=1 Edges=Rectangle1.edge(at (19.9238, 0, 0.1)) TerminalResistance=50ohm
  Rx: Terminal port=2 Edges=Rectangle2.edge(at (19.9139, 0.05, 20.1)) TerminalResistance=50ohm
  1: Lumped Port Faces=Rectangle1.face LumpedPortType=Terminal Impedance=50ohm
  2: Lumped Port Faces=Rectangle2.face LumpedPortType=Terminal RenormalizeAllTerminals=false Impedance=50ohm
  reference conductors: tx_Coil
setups:
  Setup1: HfssDrivenAuto AutoSolverSetting=Balanced Type=Interpolating
    sweep Sweep: 1MHz to 20MHz, 501 points;
source amplitudes:
  1:1: 1V 0deg
  2:1: 0V 0deg
field plots:
  Vector_H1: H Field over Cylinder1.face(all 3) tx_Coil.face(all 305) Rx_Coil.face(all 305) on Setup1 : LastAdaptive at Freq=0.0105GHz Phase=0deg
reports:
  Plot 1: Mag(Zt(Tx,Rx))^2/(Mag(Zt(Tx,Rx))^2+re(Zt(Tx,Tx))*re(Zt(Rx,Rx))) vs Freq on Setup1 : Sweep
